// Design: TwoStage_OpAmp_130nm/TwoStage_OpAmp_khuechdai_CHECK
simulator lang=spectre
global 0
include "/usr/local/IC614/tsmc13/models/RF_12_25_FSG.scs"

// TwoStage_OpAmp_130nm/TwoStage_OpAmp_khuechdai_CHECK/schematic
M6 (Out2 net16 0 0) nch_25 w=10u l=400n m=(1)*(1)
M4 (net3 net16 0 0) nch_25 w=2u l=400n m=(1)*(1)
M1 (OUT1 net13 net3 0) nch_25 w=1u l=400n m=(1)*(1)
M0 (net11 net014 net3 0) nch_25 w=1u l=400n m=(1)*(1)
M5 (Out2 OUT1 net2 net2) pch_25 w=25u l=400n m=(1)*(1)
M3 (OUT1 net11 net2 net2) pch_25 w=2.5u l=400n m=(1)*(1)
M2 (net11 net11 net2 net2) pch_25 w=2.5u l=400n m=(1)*(1)
V4 (net036 0) vsource dc=1 type=dc
V3 (net2 0) vsource dc=1.8 mag=0 type=dc
V2 (net16 0) vsource dc=771m mag=0 type=dc
C1 (Out2 0) capacitor c=5p
C0 (OUT1 Out2) capacitor c=2p
IPRB0 (net014 net028) iprobe
V0 (net13 0) vsource dc=1 mag=1 phase=0 type=sine sinedc=1 ampl=10m freq=10K
R1 (net014 net036) resistor r=10K
R0 (Out2 net028) resistor r=90K
simulatorOptions options temp=27
tran tran stop=500u maxstep=0.1u
save net13 Out2
