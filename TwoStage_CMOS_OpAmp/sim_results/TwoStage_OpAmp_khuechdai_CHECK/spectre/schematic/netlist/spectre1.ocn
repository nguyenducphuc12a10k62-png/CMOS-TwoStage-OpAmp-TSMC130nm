simulator( 'spectre )
design(	 "/home/eslam/Analog_IC/TwoStage_CMOS_OpAmp/sim_results/TwoStage_OpAmp_khuechdai_CHECK/spectre/schematic/netlist/netlist")
resultsDir( "/home/eslam/Analog_IC/TwoStage_CMOS_OpAmp/sim_results/TwoStage_OpAmp_khuechdai_CHECK/spectre/schematic" )
modelFile(
    '("/usr/local/IC614/tsmc13/tsmc13rf/../models/tsmc13rf.scs" "")
)
save( 'v "/net13" "/Out2" )
temp( 27 )
run()
