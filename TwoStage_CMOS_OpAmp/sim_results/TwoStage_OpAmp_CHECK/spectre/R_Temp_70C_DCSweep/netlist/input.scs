// Design: TwoStage_OpAmp_130nm/TwoStage_OpAmp_CHECK
simulator lang=spectre
global 0
include "/usr/local/IC614/tsmc13/models/RF_12_25_FSG.scs"

// TwoStage_OpAmp_130nm/TwoStage_OpAmp_CHECK/schematic
M6 (Out2 net16 0 0) nch_25 w=10u l=400n m=(1)*(1)
M4 (net3 net16 0 0) nch_25 w=2u l=400n m=(1)*(1)
M1 (OUT1 net13 net3 0) nch_25 w=1u l=400n m=(1)*(1)
M0 (net11 net014 net3 0) nch_25 w=1u l=400n m=(1)*(1)
M5 (Out2 OUT1 net2 net2) pch_25 w=25u l=400n m=(1)*(1)
M3 (OUT1 net11 net2 net2) pch_25 w=2.5u l=400n m=(1)*(1)
M2 (net11 net11 net2 net2) pch_25 w=2.5u l=400n m=(1)*(1)
V3 (net2 0) vsource dc=1.8 mag=0 type=dc
V2 (net16 0) vsource dc=771m mag=0 type=dc
C1 (Out2 0) capacitor c=5p
C0 (OUT1 Out2) capacitor c=2p
IPRB0 (net014 Out2) iprobe
V0 (net13 0) vsource dc=1 type=pulse val0=700.0m val1=1.3 period=10u delay=1u rise=1n fall=1n width=5u
simulatorOptions options temp=70.0
dcOp dc
dc dc dev=V0 param=dc start=0.7 stop=1.3 step=0.01
save net13 Out2
