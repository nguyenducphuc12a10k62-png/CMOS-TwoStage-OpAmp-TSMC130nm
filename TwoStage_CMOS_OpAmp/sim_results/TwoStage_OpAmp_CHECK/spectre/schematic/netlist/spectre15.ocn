simulator( 'spectre )
design(	 "/home/eslam/Analog_IC/TwoStage_CMOS_OpAmp/sim_results/TwoStage_OpAmp_CHECK/spectre/schematic/netlist/netlist")
resultsDir( "/home/eslam/Analog_IC/TwoStage_CMOS_OpAmp/sim_results/TwoStage_OpAmp_CHECK/spectre/schematic" )
modelFile(
    '("/usr/local/IC614/tsmc13/models/RF_12_25_FSG.scs" "")
)
analysis('dc ?saveOppoint t  )
envOption(
	'analysisOrder  list("dc")
)
temp( 27 )
run()
modelFile(
    '("/usr/local/IC614/tsmc13/models/RF_12_25_FSG.scs" "")
)
analysis('dc ?dev "/V0"  ?param "dc"  ?start "0.7"
		?stop "1.3"  ?step "0.01"  )
save( 'v "/net13" "/Out2" )
run()
selectResult( 'dc )
plot(getData("/net13") getData("/Out2") )
modelFile(
    '("/usr/local/IC614/tsmc13/models/RF_12_25_FSG.scs" "")
)
analysis('tran ?stop "20u"  ?maxstep "1n"  )
envOption(
	'analysisOrder  list("tran")
)
run()
selectResult( 'tran )
plot(getData("/net13") getData("/Out2") )
modelFile(
    '("/usr/local/IC614/tsmc13/models/RF_12_25_FSG.scs" "")
)
analysis('stb ?start "1"  ?stop "1e9"  ?dec "100"
		?probe "/IPRB0"  )
envOption(
	'analysisOrder  list("stb")
)
option(	'temp  "0.0"
)
delete( 'save 'v /net13 /Out2 )
temp( 0.0 )
run()
modelFile(
    '("/usr/local/IC614/tsmc13/models/RF_12_25_FSG.scs" "")
)
option(	'temp  "70.0"
)
temp( 70.0 )
run()
modelFile(
    '("/usr/local/IC614/tsmc13/models/RF_12_25_FSG.scs" "")
)
analysis('dc ?saveOppoint t  ?dev "/V0"  ?param "dc"
		?start "0.7"  ?stop "1.3"  ?step "0.01"  )
envOption(
	'analysisOrder  list("dc")
)
option(	'temp  "0.0"
)
save( 'v "/net13" "/Out2" )
temp( 0.0 )
run()
selectResult( 'dc )
plot(getData("/net13") getData("/Out2") )
modelFile(
    '("/usr/local/IC614/tsmc13/models/RF_12_25_FSG.scs" "")
)
option(	'temp  "70.0"
)
temp( 70.0 )
run()
selectResult( 'dc )
plot(getData("/net13") getData("/Out2") )
modelFile(
    '("/usr/local/IC614/tsmc13/models/RF_12_25_FSG.scs" "")
)
run()
selectResult( 'dc )
plot(getData("/net13") getData("/Out2") )
modelFile(
    '("/home/eslam/cadence_corners/opamp_TT.scs" "")
)
analysis('stb ?start "1"  ?stop "1e9"  ?dec "100"
		?probe "/IPRB0"  )
envOption(
	'analysisOrder  list("stb")
)
option(	'temp  "27"
)
delete( 'save 'v /net13 /Out2 )
temp( 27 )
run()
modelFile(
    '("/home/eslam/cadence_corners/opamp_FF.scs" "")
)
run()
modelFile(
    '("/home/eslam/cadence_corners/opamp_SS.scs" "")
)
run()
modelFile(
    '("/home/eslam/cadence_corners/opamp_FS.scs" "")
)
run()
modelFile(
    '("/home/eslam/cadence_corners/opamp_SF.scs" "")
)
run()
